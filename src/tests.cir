V1 in 0 SIN(0 5 1000)
.model Dtest D(Is = 1e-14)

R1 in out 1k
D1 out 0 Dtest

.TRAN 1u 5m
.END
