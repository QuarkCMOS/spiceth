V1 1 0 sin 1 2 10 0.05 0 30
R1 1 2 100
C1 2 0 16u
.TRAN 1e-5 0.4
