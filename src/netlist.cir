V1 in 0 DC 1
E1 out 0 in fb 1000
R1 out fb 10k
C1 fb 0 1u
.TRAN 1e-5 0.01
