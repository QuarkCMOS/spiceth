V1 n0 GND sin 1 2 10 0.05 0 30
R1 n0 n1 100
C1 n1 GND 16u
.IC V(n1)=0.5
.TRAN 1e-5 0.4
