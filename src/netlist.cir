V1 in 0 DC 12 AC 1e-20
R1 in out 1k
C1 out 0 1u
.AC DEC 10 1e-3 1e6
