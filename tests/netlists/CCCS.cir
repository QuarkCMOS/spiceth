VCTRL sense 0 DC 1

R1 sense 0 1k

F1 out 0 VCTRL 2

R2 out 0 1k

.OP
.END
