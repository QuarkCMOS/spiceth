V1 in 0 AC 1

L1 in out 10m
R1 out 0 100

.AC DEC 100 1 1Meg
.END
