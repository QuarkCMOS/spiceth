V1 in 0 AC 1
.model Dtest D(Is = 1e-14)

R1 in out 1k
D1 out 0 Dtest

.AC DEC 10 1 1e4
.END
