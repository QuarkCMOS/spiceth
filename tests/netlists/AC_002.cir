V1 in 0 AC 1

C1 in out 1u
R1 out 0 1k

.AC DEC 100 1 1Meg
.END
