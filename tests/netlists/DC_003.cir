I1 n1 0 10
R1 n1 0 1k
.dc I1 0 10 1
.end
