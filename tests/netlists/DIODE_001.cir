.MODEL DIO D(IS=1e-14)
V1 anode 0 DC 1

R1 anode cathode 1k

D1 cathode 0 DIO

.OP
.END
