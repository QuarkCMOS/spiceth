V1 in 0 AC 1

R1 in out 10
L1 out n2 1m
C1 n2 0 1u

.AC DEC 200 10 1Meg
.END
