V1 n1 0 DC 10

R1 n1 0 1k
R2 n1 0 1k

.OP
.END
