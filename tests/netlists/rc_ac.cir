RC AC low-pass filter test
* fc = 1/(2*pi*1k*1u) = 159.15 Hz

V1  in   GND  AC 1
R1  in   out  1k
C1  out  GND  1u

.AC DEC 10 1 100k
.end
