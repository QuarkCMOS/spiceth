.MODEL DIO D(Is=1e-14)
V1 n1 0 DC 1
R1 n1 n2 100
D1 n2 0 DIO

.DC V1 0 5 0.01
.END
