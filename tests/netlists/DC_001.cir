V1 n1 0 DC 0

R1 n1 0 1k

.DC V1 0 10 1
.END
