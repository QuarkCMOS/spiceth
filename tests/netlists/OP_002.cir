* OP_002

I1 n1 0 DC 2m
R1 n1 0 1k

.OP
.END
