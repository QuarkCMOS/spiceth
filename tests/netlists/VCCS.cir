V1 ctrl 0 DC 2

G1 out 0 ctrl 0 0.01

R1 out 0 1k

.OP
.END
