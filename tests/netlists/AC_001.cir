V1 in 0 AC 1

R1 in out 1k
C1 out 0 1u

.AC DEC 100 1 1Meg
.END
