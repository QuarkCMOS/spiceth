.MODEL DIO D(IS=1e-14)
V1 anode 0 DC -5

D1 anode 0 DIO

.OP
.END
